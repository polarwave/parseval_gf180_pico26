** sch_path: /foss/designs/libs/tb_analog/tb_rms_det/tb_rms_det.sch
**.subckt tb_rms_det
x1 vdd net2 net1 vinp vinn i_ref vss quad_diff_in
x2 vdd net2 i_ref vss iref
x3 vdd net1 vrms vss rms_out
C1 vrms vss {c_avg}
**** begin user architecture code
External Averaging Capacitor
**** end user architecture code
**.ends

* expanding   symbol:  libs/core_analog/quad_diff_in/quad_diff_in.sym # of pins=7
** sym_path: /foss/designs/libs/core_analog/quad_diff_in/quad_diff_in.sym
** sch_path: /foss/designs/libs/core_analog/quad_diff_in/quad_diff_in.sch
.subckt quad_diff_in vdd Mref_src Mref_even vinp vinn Mref_sink vss
*.iopin vdd
*.iopin vss
*.ipin vinp
*.ipin vinn
*.ipin Mref_src
*.ipin Mref_sink
*.opin Mref_even
XM1 vdd vinp net1 vss nfet_05v0 L={L_UNIT} W={W_UNIT} nf=1 ad='int((nf+1)/2) * W/nf * 0.18u' as='int((nf+2)/2) * W/nf * 0.18u' pd='2*int((nf+1)/2) * (W/nf + 0.18u)'
+ ps='2*int((nf+2)/2) * (W/nf + 0.18u)' nrd='0.18u / W' nrs='0.18u / W' sa=0 sb=0 sd=0 m={N_SKEW}
XM3 Mref_even vinp net2 vss nfet_05v0 L={L_UNIT} W={W_UNIT} nf=1 ad='int((nf+1)/2) * W/nf * 0.18u' as='int((nf+2)/2) * W/nf * 0.18u'
+ pd='2*int((nf+1)/2) * (W/nf + 0.18u)' ps='2*int((nf+2)/2) * (W/nf + 0.18u)' nrd='0.18u / W' nrs='0.18u / W' sa=0 sb=0 sd=0
XM4 Mref_even vinn net1 vss nfet_05v0 L={L_UNIT} W={W_UNIT} nf=1 ad='int((nf+1)/2) * W/nf * 0.18u' as='int((nf+2)/2) * W/nf * 0.18u'
+ pd='2*int((nf+1)/2) * (W/nf + 0.18u)' ps='2*int((nf+2)/2) * (W/nf + 0.18u)' nrd='0.18u / W' nrs='0.18u / W' sa=0 sb=0 sd=0
XM5 net1 Mref_sink vss vss nfet_05v0 L={L_BIAS} W={W_BIAS} nf=1 ad='int((nf+1)/2) * W/nf * 0.18u' as='int((nf+2)/2) * W/nf * 0.18u'
+ pd='2*int((nf+1)/2) * (W/nf + 0.18u)' ps='2*int((nf+2)/2) * (W/nf + 0.18u)' nrd='0.18u / W' nrs='0.18u / W' sa=0 sb=0 sd=0 m={N_SKEW
XM6 net2 Mref_sink vss vss nfet_05v0 L={L_BIAS} W={W_BIAS} nf=1 ad='int((nf+1)/2) * W/nf * 0.18u' as='int((nf+2)/2) * W/nf * 0.18u' pd='2*int((nf+1)/2)
+ * (W/nf + 0.18u)' ps='2*int((nf+2)/2) * (W/nf + 0.18u)' nrd='0.18u / W' nrs='0.18u / W' sa=0 sb=0 sd=0 m={N_SKEW
XM7 Mref_even Mref_src vdd vdd pfet_05v0 L={L_PBIAS} W={W_PBIAS} nf=1 ad='int((nf+1)/2) * W/nf * 0.18u' as='int((nf+2)/2) * W/nf * 0.18u'
+ pd='2*int((nf+1)/2) * (W/nf + 0.18u)' ps='2*int((nf+2)/2) * (W/nf + 0.18u)' nrd='0.18u / W' nrs='0.18u / W' sa=0 sb=0 sd=0
XM8 Mref_even Mref_even vdd vdd pfet_05v0 L={L_EVEN} W={W_EVEN} nf=1 ad='int((nf+1)/2) * W/nf * 0.18u' as='int((nf+2)/2) * W/nf * 0.18u'
+ pd='2*int((nf+1)/2) * (W/nf + 0.18u)' ps='2*int((nf+2)/2) * (W/nf + 0.18u)' nrd='0.18u / W' nrs='0.18u / W' sa=0 sb=0 sd=0
XM2 vdd vinn net2 vss nfet_05v0 L={L_UNIT} W={W_UNIT} nf=1 ad='int((nf+1)/2) * W/nf * 0.18u' as='int((nf+2)/2) * W/nf * 0.18u' pd='2*int((nf+1)/2) * (W/nf + 0.18u)'
+ ps='2*int((nf+2)/2) * (W/nf + 0.18u)' nrd='0.18u / W' nrs='0.18u / W' sa=0 sb=0 sd=0 m={N_SKEW}
.ends

* expanding   symbol:  libs/core_analog/iref/iref.sym # of pins=5
** sym_path: /foss/designs/libs/core_analog/iref/iref.sym
** sch_path: /foss/designs/libs/core_analog/iref/iref.sch
.subckt iref vdd Mref_src Iref vss
*.ipin Iref
*.iopin vdd
*.iopin vss
*.opin Mref_src
*.opin Iref
XM2 Mref_src Mref_src vdd vdd pfet_05v0 L={L_PBIAS} W={W_PBIAS} nf=1 ad='int((nf+1)/2) * W/nf * 0.18u' as='int((nf+2)/2) * W/nf * 0.18u'
+ pd='2*int((nf+1)/2) * (W/nf + 0.18u)' ps='2*int((nf+2)/2) * (W/nf + 0.18u)' nrd='0.18u / W' nrs='0.18u / W' sa=0 sb=0 sd=0
XM1 Iref Iref vss vss nfet_05v0 L={L_BIAS} W={W_BIAS} nf=1 ad='int((nf+1)/2) * W/nf * 0.18u' as='int((nf+2)/2) * W/nf * 0.18u' pd='2*int((nf+1)/2) * (W/nf + 0.18u)'
+ ps='2*int((nf+2)/2) * (W/nf + 0.18u)' nrd='0.18u / W' nrs='0.18u / W' sa=0 sb=0 sd=0
XM3 Mref_src Iref vss vss nfet_05v0 L={L_BIAS} W={W_BIAS} nf=1 ad='int((nf+1)/2) * W/nf * 0.18u' as='int((nf+2)/2) * W/nf * 0.18u'
+ pd='2*int((nf+1)/2) * (W/nf + 0.18u)' ps='2*int((nf+2)/2) * (W/nf + 0.18u)' nrd='0.18u / W' nrs='0.18u / W' sa=0 sb=0 sd=0 m=2
.ends

* expanding   symbol:  libs/core_analog/rms_out/rms_out.sym # of pins=4
** sym_path: /foss/designs/libs/core_analog/rms_out/rms_out.sym
** sch_path: /foss/designs/libs/core_analog/rms_out/rms_out.sch
.subckt rms_out vdd Mref_even vrms vss
*.ipin Mref_even
*.iopin vdd
*.iopin vss
*.opin vrms
XM1 vrms Mref_even vdd vdd pfet_05v0 L={L_EVEN} W={W_EVEN} nf=1 ad='int((nf+1)/2) * W/nf * 0.18u' as='int((nf+2)/2) * W/nf * 0.18u'
+ pd='2*int((nf+1)/2) * (W/nf + 0.18u)' ps='2*int((nf+2)/2) * (W/nf + 0.18u)' nrd='0.18u / W' nrs='0.18u / W' sa=0 sb=0 sd=0 m={M_EVEN}
XM2 vrms vrms vss vss nfet_05v0 L={L_OUT} W={W_OUT} nf=1 ad='int((nf+1)/2) * W/nf * 0.18u' as='int((nf+2)/2) * W/nf * 0.18u' pd='2*int((nf+1)/2) * (W/nf + 0.18u)'
+ ps='2*int((nf+2)/2) * (W/nf + 0.18u)' nrd='0.18u / W' nrs='0.18u / W' sa=0 sb=0 sd=0
.ends

.end
